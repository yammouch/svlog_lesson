// irun ex03.vams amsControlSpectre.scs

`timescale 1ns/1ns

`include "constants.vams"
`include "disciplines.vams"

module dut(
 input wreal signal
);

real signal_i;

analog begin
  signal_i = signal;
end

always @(signal_i) $display(signal_i);

endmodule

module ex02;

real signal;

dut i_dut(.signal(signal));

initial begin
  signal = 0.0; repeat (4) begin
    signal = signal + 1.0; #2;
  end
end

endmodule
