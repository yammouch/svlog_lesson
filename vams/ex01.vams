`include "constants.vams"
`include "disciplines.vams"

module ex01;

initial begin
  $display("Hello, world");
end

endmodule
